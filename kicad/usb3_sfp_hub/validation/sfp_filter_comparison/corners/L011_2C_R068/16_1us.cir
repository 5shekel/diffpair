SFP candidate L011_2C_R068, corner 16
Rind feed lx 1e-09
Lfilter lx out 1.32e-07
Cbypass out 0 100n
Rcap out cpos 0.0025
Cbulk cpos damp 2.2e-05
Rdamp damp 0 0.06732
Vfeed feed 0 DC 3.3
Iload out 0 PWL(0 0 0.0002 0 0.000201 .6 0.000236 .6 0.000241 .45 0.0008 .45 0.000801 0 1m 0)
.tran 0.05u 1m
.end
