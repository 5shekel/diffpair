SFP candidate L047_4C_R068, corner 31
Rind feed lx 0.02790602
Lfilter lx out 5.64e-07
Cbypass out 0 100n
Rcap out cpos 0.00875
Cbulk cpos damp 9.68e-05
Rdamp damp 0 0.07072
Vfeed feed 0 DC 3.3
Iload out 0 PWL(0 0 0.0002 0 0.000201 .6 0.000236 .6 0.000241 .45 0.0008 .45 0.000801 0 1m 0)
.tran 0.05u 1m
.end
