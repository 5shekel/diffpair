SFP reference filter nominal_typical
Vfeed feed 0 DC 3.3 AC 1
Rind feed lx 0.043
Lfilter lx out 4.7e-06
Cbypass out 0 100n
Rcap out cpos 0.0205641004347
Cbulk cpos damp 1.52124066328e-05
Rdamp damp 0 0.43
Iload out 0 PWL(0 0 200u 0 210u 0.6 245u 0.6 250u 0.45 1000u 0.45)
.tran 0.1u 1m
.end
